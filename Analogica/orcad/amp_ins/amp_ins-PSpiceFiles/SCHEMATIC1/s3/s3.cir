** Profile: "SCHEMATIC1-s3"  [ D:\dcser\Documents\Universidad\ISE\B2\amp_ins\amp_ins-pspicefiles\schematic1\s3.sim ]

** Creating circuit file "s3.cir"
** WARNING: THIS AUTOMATICALLY GENERATED FILE MAY BE OVERWRITTEN BY SUBSEQUENT SIMULATIONS

*Libraries:
* Profile Libraries :
* Local Libraries :
* From [PSPICE NETLIST] section of C:\Users\dcser\AppData\Roaming\SPB_Data\cdssetup\OrCAD_PSpice\25.1.0\PSpice.ini file:
.lib "D:\dcser\Documents\Universidad\ISE\B2\sloj050b\OP07C.LIB"
.lib "D:\dcser\Documents\Universidad\ISE\B2\sboc084g\OPAx333.LIB"
.lib "D:\dcser\Documents\Universidad\ISE\B2\sglm009d\lmx24_lm2902.lib"
.lib "D:\dcser\Documents\Universidad\ISE\B2\sloc063b\TLV2372_PSPICE_AIO\TLV2372.LIB"
.lib "C:\Cadence\OrCADX_25.1\tools\pspice\Library\opamp.lib"
.lib "D:\dcser\Documents\Universidad\ISE\B2\snom268c\lmx58_lm2904.lib"
.lib "nom.lib"

*Analysis directives:
.TRAN  0 10s 0
.OPTIONS ADVCONV
.PROBE64 V(alias(*)) I(alias(*)) W(alias(*)) D(alias(*)) NOISE(alias(*))
.INC "..\SCHEMATIC1.net"

.END
